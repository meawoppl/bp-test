Two synchronized bridges: reservoir charge-pulse sensitivity
Vbat battery 0 30
Rlead battery n0 .05
Llead n0 bus 5e-06
Rin bus ci 0.005
Cin ci 0 3.2e-05
Rfeed1 bus nf1 .02
Lfeed1 nf1 b1 .2u
Rcap1 b1 c1 0.005
Cbank1 c1 0 3.2e-05
Rfeed2 bus nf2 .02
Lfeed2 nf2 b2 .2u
Rcap2 b2 c2 0.005
Cbank2 c2 0 3.2e-05
Iload1 b1 0 PWL(0 0 1e-05 0 1e-05 0 1.005e-05 50 1.192e-05 50 1.197e-05 0 2.66666666667e-05 0 2.67166666667e-05 50 2.85866666667e-05 50 2.86366666667e-05 0 4.33333333333e-05 0 4.33833333333e-05 50 4.52533333333e-05 50 4.53033333333e-05 0 6e-05 0 6.005e-05 50 6.192e-05 50 6.197e-05 0 7.66666666667e-05 0 7.67166666667e-05 50 7.85866666667e-05 50 7.86366666667e-05 0 9.33333333333e-05 0 9.33833333333e-05 50 9.52533333333e-05 50 9.53033333333e-05 0 0.00011 0 0.00011005 50 0.00011192 50 0.00011197 0 0.000126666666667 0 0.000126716666667 50 0.000128586666667 50 0.000128636666667 0 0.000143333333333 0 0.000143383333333 50 0.000145253333333 50 0.000145303333333 0 0.00016 0 0.00016005 50 0.00016192 50 0.00016197 0 0.000176666666667 0 0.000176716666667 50 0.000178586666667 50 0.000178636666667 0 0.000193333333333 0 0.000193383333333 50 0.000195253333333 50 0.000195303333333 0 0.00021 0 0.00021005 50 0.00021192 50 0.00021197 0 0.000226666666667 0 0.000226716666667 50 0.000228586666667 50 0.000228636666667 0 0.000243333333333 0 0.000243383333333 50 0.000245253333333 50 0.000245303333333 0 0.00026 0 0.00026005 50 0.00026192 50 0.00026197 0 0.000276666666667 0 0.000276716666667 50 0.000278586666667 50 0.000278636666667 0 0.000293333333333 0 0.000293383333333 50 0.000295253333333 50 0.000295303333333 0 0.00031 0 0.00031005 50 0.00031192 50 0.00031197 0 0.000326666666667 0 0.000326716666667 50 0.000328586666667 50 0.000328636666667 0 0.000343333333333 0 0.000343383333333 50 0.000345253333333 50 0.000345303333333 0 0.00036 0 0.00036005 50 0.00036192 50 0.00036197 0 0.000376666666667 0 0.000376716666667 50 0.000378586666667 50 0.000378636666667 0 0.000393333333333 0 0.000393383333333 50 0.000395253333333 50 0.000395303333333 0 0.0008 0)
Iload2 b2 0 PWL(0 0 1e-05 0 1e-05 0 1.005e-05 50 1.192e-05 50 1.197e-05 0 2.66666666667e-05 0 2.67166666667e-05 50 2.85866666667e-05 50 2.86366666667e-05 0 4.33333333333e-05 0 4.33833333333e-05 50 4.52533333333e-05 50 4.53033333333e-05 0 6e-05 0 6.005e-05 50 6.192e-05 50 6.197e-05 0 7.66666666667e-05 0 7.67166666667e-05 50 7.85866666667e-05 50 7.86366666667e-05 0 9.33333333333e-05 0 9.33833333333e-05 50 9.52533333333e-05 50 9.53033333333e-05 0 0.00011 0 0.00011005 50 0.00011192 50 0.00011197 0 0.000126666666667 0 0.000126716666667 50 0.000128586666667 50 0.000128636666667 0 0.000143333333333 0 0.000143383333333 50 0.000145253333333 50 0.000145303333333 0 0.00016 0 0.00016005 50 0.00016192 50 0.00016197 0 0.000176666666667 0 0.000176716666667 50 0.000178586666667 50 0.000178636666667 0 0.000193333333333 0 0.000193383333333 50 0.000195253333333 50 0.000195303333333 0 0.00021 0 0.00021005 50 0.00021192 50 0.00021197 0 0.000226666666667 0 0.000226716666667 50 0.000228586666667 50 0.000228636666667 0 0.000243333333333 0 0.000243383333333 50 0.000245253333333 50 0.000245303333333 0 0.00026 0 0.00026005 50 0.00026192 50 0.00026197 0 0.000276666666667 0 0.000276716666667 50 0.000278586666667 50 0.000278636666667 0 0.000293333333333 0 0.000293383333333 50 0.000295253333333 50 0.000295303333333 0 0.00031 0 0.00031005 50 0.00031192 50 0.00031197 0 0.000326666666667 0 0.000326716666667 50 0.000328586666667 50 0.000328636666667 0 0.000343333333333 0 0.000343383333333 50 0.000345253333333 50 0.000345303333333 0 0.00036 0 0.00036005 50 0.00036192 50 0.00036197 0 0.000376666666667 0 0.000376716666667 50 0.000378586666667 50 0.000378636666667 0 0.000393333333333 0 0.000393383333333 50 0.000395253333333 50 0.000395303333333 0 0.0008 0)
.tran 20n 800u
.control
set wr_singlescale
set wr_vecnames
run
wrdata wave.dat v(bus) v(b1) i(Llead) v(b1,c1)
quit
.endc
.end
