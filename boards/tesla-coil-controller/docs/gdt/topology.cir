GDT ideal bridge / lumped load approximation
Vdrive src 0 PWL(0 0 1e-05 0 1e-05 0 1.01e-05 24 2.64666666667e-05 24 2.65666666667e-05 0 2.66666666667e-05 0 2.67666666667e-05 -24 4.31333333333e-05 -24 4.32333333333e-05 0 4.33333333333e-05 0 4.34333333333e-05 24 5.98e-05 24 5.99e-05 0 6e-05 0 6.01e-05 -24 7.64666666667e-05 -24 7.65666666667e-05 0 7.66666666667e-05 0 7.67666666667e-05 24 9.31333333333e-05 24 9.32333333333e-05 0 9.33333333333e-05 0 9.34333333333e-05 -24 0.0001098 -24 0.0001099 0 0.00011 0 0.0001101 24 0.000126466666667 24 0.000126566666667 0 0.000126666666667 0 0.000126766666667 -24 0.000143133333333 -24 0.000143233333333 0 0.000143333333333 0 0.000143433333333 24 0.0001598 24 0.0001599 0 0.00016 0 0.0001601 -24 0.000176466666667 -24 0.000176566666667 0 0.000176666666667 0 0.000176766666667 24 0.000193133333333 24 0.000193233333333 0 0.000193333333333 0 0.000193433333333 -24 0.0002098 -24 0.0002099 0 0.00021 0 0.0002101 24 0.000226466666667 24 0.000226566666667 0 0.000226666666667 0 0.000226766666667 -24 0.000243133333333 -24 0.000243233333333 0 0.000243333333333 0 0.000243433333333 24 0.0002598 24 0.0002599 0 0.00026 0 0.0002601 -24 0.000276466666667 -24 0.000276566666667 0 0.000276666666667 0 0.0004 0)
Rbridge src blk 0.02
Cblock blk damp 2.2u
Rleak blk damp 1G
Rwire damp leak 0.15
Lleak leak pri 5e-07
Lmag pri 0 1m
Rgate pri gate 1.275
Cgate gate 0 8e-07
Rsn blk sn 15
Csn sn damp 1u
.tran 10n 400u
.control
set wr_singlescale
set wr_vecnames
run
wrdata wave.dat v(src) v(pri) v(gate) i(Vdrive) v(blk,damp) v(blk,sn)
quit
.endc
.end
